ADE simulation setup
Run mode: Single Run, Sweeps and Corners
Tests:
  devices:inverter_pulse_tb:1: devices/inverter_pulse_tb/config, simulator spectre
    Variables: vSupply = 1.1
