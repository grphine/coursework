ADE simulation setup
Test devices:inverter_pulse_tb:1: devices/inverter_pulse_tb/config, simulator spectre
  Models: /eda/designKits/gpdk045_v_6_0/gpdk045/../models/spectre/gpdk045.scs[tt]
  Variables: vSupply = 1.1
  Temperature: 27
  Analysis tran: stop=600n errpreset=conservative method=gear2only
  Signals: /input, /output
Run mode: Single Run, Sweeps and Corners
