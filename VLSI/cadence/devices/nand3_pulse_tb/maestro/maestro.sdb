ADE simulation setup
Run mode: Single Run, Sweeps and Corners
Tests:
  devices:nand3_pulse_tb:1: devices/nand3_pulse_tb/schematic, simulator spectre
    Variables: vSupply = 1.1
