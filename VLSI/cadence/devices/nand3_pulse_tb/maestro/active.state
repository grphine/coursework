ADE simulation setup
Test devices:nand3_pulse_tb:1: devices/nand3_pulse_tb/schematic, simulator spectre
  Models: /eda/designKits/gpdk045_v_6_0/gpdk045/../models/spectre/gpdk045.scs[tt]
  Variables: vSupply = 1.1
  Temperature: 27
  Analysis tran: stop=700n errpreset=conservative
  Signals: /inA, /inB, /inC, /output
Run mode: Single Run, Sweeps and Corners
