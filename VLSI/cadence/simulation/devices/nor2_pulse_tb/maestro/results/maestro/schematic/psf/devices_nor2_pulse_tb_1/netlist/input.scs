// Design: devices/nor2_pulse_tb
simulator lang=spectre
global 0 vdd!
parameters vSupply=1.1
include "/eda/designKits/gpdk045_v_6_0/gpdk045/../models/spectre/gpdk045.scs" section=tt

// devices/nor2/schematic
subckt nor2 A B out
    PM4 (out B net12 vdd!) g45p1svt w=(240n) l=45n nf=1 m=(1)
    PM3 (net12 A vdd! vdd!) g45p1svt w=(240n) l=45n nf=1 m=(1)
    NM0 (out B 0 0) g45n1svt w=(120n) l=45n nf=1 m=(1)
    NM1 (out A 0 0) g45n1svt w=(120n) l=45n nf=1 m=(1)
ends nor2

// devices/nor2_pulse_tb/schematic
C0 (_net0 0) capacitor c=1f
V0 (vdd! 0) vsource dc=vSupply type=dc
V4 (inB 0) vsource type=pulse val0=0 val1=vSupply period=200n delay=108n rise=2n fall=2n width=98n
V1 (inA 0) vsource type=pulse val0=0 val1=vSupply period=100n delay=48n rise=2n fall=2n width=48n
I7 (inA inB _net0) nor2
simulatorOptions options temp=27
tran tran stop=600n errpreset=conservative method=gear2only save=allpub
save inA inB _net0
saveOptions options save=all pwr=all
