// Design: devices/nor3_pulse_tb
simulator lang=spectre
global 0 vdd!
parameters vSupply=1.1
include "/eda/designKits/gpdk045_v_6_0/gpdk045/../models/spectre/gpdk045.scs" section=tt

// devices/nor3/schematic
subckt nor3 A B C out
    PM2 (out C net15 vdd!) g45p1svt w=(240n) l=45n nf=1 m=(1)
    PM1 (net15 B net16 vdd!) g45p1svt w=(240n) l=45n nf=1 m=(1)
    PM0 (net16 A vdd! vdd!) g45p1svt w=(240n) l=45n nf=1 m=(1)
    NM2 (out B 0 0) g45n1svt w=(120n) l=45n nf=1 m=(1)
    NM1 (out A 0 0) g45n1svt w=(120n) l=45n nf=1 m=(1)
    NM0 (out C 0 0) g45n1svt w=(120n) l=45n nf=1 m=(1)
ends nor3

// devices/nor3_pulse_tb/schematic
C0 (_net0 0) capacitor c=1f
V0 (vdd! 0) vsource dc=vSupply type=dc
V4 (inB 0) vsource type=pulse val0=0 val1=vSupply period=200n delay=108n rise=2n fall=2n width=98n
V1 (inA 0) vsource type=pulse val0=0 val1=vSupply period=100n delay=48n rise=2n fall=2n width=48n
V2 (inC 0) vsource type=pulse val0=0 val1=vSupply period=400n delay=148n rise=2n fall=2n width=198n
I8 (inA inB inC _net0) nor3
simulatorOptions options temp=27
tran tran stop=700n errpreset=conservative
save inA inB inC _net0
saveOptions options save=all pwr=all
