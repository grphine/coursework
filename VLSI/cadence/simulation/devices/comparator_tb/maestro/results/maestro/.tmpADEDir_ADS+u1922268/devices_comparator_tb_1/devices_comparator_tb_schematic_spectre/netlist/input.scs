// Design: devices/comparator_tb
simulator lang=spectre
global 0 vdd!
parameters vSupply=1.1
include "/eda/designKits/gpdk045_v_6_0/gpdk045/../models/spectre/gpdk045.scs" section=tt

// devices/inverter/schematic
subckt inverter in out
    NM0 (out in 0 0) g45n1svt w=(120n) l=45n nf=1 m=(1)
    PM0 (out in vdd! vdd!) g45p1svt w=(240n) l=45n nf=1 m=(1)
ends inverter

// devices/nand2/schematic
subckt nand2 A B out
    NM1 (net12 B 0 0) g45n1svt w=(120n) l=45n nf=1 m=(1)
    NM0 (out A net12 0) g45n1svt w=(120n) l=45n nf=1 m=(1)
    PM1 (out B vdd! vdd!) g45p1svt w=(240n) l=45n nf=1 m=(1)
    PM0 (out A vdd! vdd!) g45p1svt w=(240n) l=45n nf=1 m=(1)
ends nand2

// devices/nand3/schematic
subckt nand3 A B C out
    PM2 (out C vdd! vdd!) g45p1svt w=(240n) l=45n nf=1 m=(1)
    PM1 (out B vdd! vdd!) g45p1svt w=(240n) l=45n nf=1 m=(1)
    PM0 (out A vdd! vdd!) g45p1svt w=(240n) l=45n nf=1 m=(1)
    NM2 (net14 C 0 0) g45n1svt w=(120n) l=45n nf=1 m=(1)
    NM1 (net15 B net14 0) g45n1svt w=(120n) l=45n nf=1 m=(1)
    NM0 (out A net15 0) g45n1svt w=(120n) l=45n nf=1 m=(1)
ends nand3

// devices/nor2/schematic
subckt nor2 A B out
    PM4 (out B net12 vdd!) g45p1svt w=(240n) l=45n nf=1 m=(1)
    PM3 (net12 A vdd! vdd!) g45p1svt w=(240n) l=45n nf=1 m=(1)
    NM0 (out B 0 0) g45n1svt w=(120n) l=45n nf=1 m=(1)
    NM1 (out A 0 0) g45n1svt w=(120n) l=45n nf=1 m=(1)
ends nor2

// devices/nor3/schematic
subckt nor3 A B C out
    PM2 (out C net15 vdd!) g45p1svt w=(240n) l=45n nf=1 m=(1)
    PM1 (net15 B net16 vdd!) g45p1svt w=(240n) l=45n nf=1 m=(1)
    PM0 (net16 A vdd! vdd!) g45p1svt w=(240n) l=45n nf=1 m=(1)
    NM2 (out B 0 0) g45n1svt w=(120n) l=45n nf=1 m=(1)
    NM1 (out A 0 0) g45n1svt w=(120n) l=45n nf=1 m=(1)
    NM0 (out C 0 0) g45n1svt w=(120n) l=45n nf=1 m=(1)
ends nor3

// devices/comparator/schematic
subckt comparator A0 A1 A2 A3 B0 B1 B2 B3 E G L
    I19 (net65 net1) inverter
    I8 (B0 net54) inverter
    I7 (B1 net32) inverter
    I6 (B2 net7) inverter
    I5 (B3 net35) inverter
    I4 (A0 net38) inverter
    I3 (A1 net13) inverter
    I2 (A2 net44) inverter
    I1 (A3 net17) inverter
    I21 (net53 net31 net19) nand2
    I20 (net1 net19 net51) nand2
    I18 (net26 net37 net25) nand2
    I17 (net29 net43 net65) nand2
    I14 (net32 A1 net31) nand2
    I13 (net35 A3 net52) nand2
    I12 (net38 B0 net37) nand2
    I11 (net13 B1 net26) nand2
    I10 (net44 B2 net43) nand2
    I9 (net17 B3 net29) nand2
    I22 (net50 net51 net52 G) nand3
    I16 (net54 A0 net26 net53) nand3
    I15 (net29 A2 net7 net50) nand3
    I23 (E G L) nor2
    I24 (net65 net25 G E) nor3
ends comparator

// devices/comparator_tb/schematic
C2 (G 0) capacitor c=1f
C1 (E 0) capacitor c=1f
C0 (L 0) capacitor c=1f
V0 (vdd! 0) vsource dc=vSupply type=dc
V8 (B3 0) vsource type=pulse val0=0 val1=vSupply period=6.4u delay=3.198u rise=2n fall=2n width=3.198u
V7 (B2 0) vsource type=pulse val0=0 val1=vSupply period=1.6u delay=798n rise=2n fall=2n width=798n
V6 (B1 0) vsource type=pulse val0=0 val1=vSupply period=400n delay=198n rise=2n fall=2n width=198n
V5 (B0 0) vsource type=pulse val0=0 val1=vSupply period=100n delay=48n rise=2n fall=2n width=48n
V3 (A0 0) vsource type=pulse val0=0 val1=vSupply period=200n delay=98n rise=2n fall=2n width=98n
V4 (A2 0) vsource type=pulse val0=0 val1=vSupply period=3.2u delay=1.598u rise=2n fall=2n width=1.598u
V1 (A3 0) vsource type=pulse val0=0 val1=vSupply period=12.8u delay=6.398u rise=2n fall=2n width=6.398u
V2 (A1 0) vsource type=pulse val0=0 val1=vSupply period=800n delay=398n rise=2n fall=2n width=398n
I17 (A0 A1 A2 A3 B0 B1 B2 B3 E G L) comparator
simulatorOptions options temp=27
tran tran stop=13u errpreset=conservative
save A3 A2 A1 A0 B3 B2 B1 B0 G E L
saveOptions options save=all pwr=all
