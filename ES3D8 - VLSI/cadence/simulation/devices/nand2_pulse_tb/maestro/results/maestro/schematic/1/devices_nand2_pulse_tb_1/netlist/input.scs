// Design: devices/nand2_pulse_tb
simulator lang=spectre
global 0 vdd!
parameters vSupply=1.1
include "/eda/designKits/gpdk045_v_6_0/gpdk045/../models/spectre/gpdk045.scs" section=tt

// devices/nand2/schematic
subckt nand2 A B out
    NM1 (net12 B 0 0) g45n1svt w=(120n) l=45n nf=1 m=(1)
    NM0 (out A net12 0) g45n1svt w=(120n) l=45n nf=1 m=(1)
    PM1 (out B vdd! vdd!) g45p1svt w=(240n) l=45n nf=1 m=(1)
    PM0 (out A vdd! vdd!) g45p1svt w=(240n) l=45n nf=1 m=(1)
ends nand2

// devices/nand2_pulse_tb/schematic
C0 (_net0 0) capacitor c=1f
V0 (vdd! 0) vsource dc=vSupply type=dc
V4 (inB 0) vsource type=pulse val0=0 val1=vSupply period=200n delay=108n rise=2n fall=2n width=98n
V1 (inA 0) vsource type=pulse val0=0 val1=vSupply period=100n delay=48n rise=2n fall=2n width=48n
I5 (inA inB _net0) nand2
simulatorOptions options temp=27
tran tran stop=600n errpreset=conservative method=gear2only save=allpub
save inA inB _net0
saveOptions options save=all pwr=all
