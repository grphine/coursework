ADE simulation setup
Test devices:comparator_tb:1: devices/comparator_tb/schematic, simulator spectre
  Models: /eda/designKits/gpdk045_v_6_0/gpdk045/../models/spectre/gpdk045.scs[tt]
  Variables: vSupply = 1.1
  Temperature: 27
  Analysis tran: stop=13u errpreset=conservative
  Signals: /A3, /A2, /A1, /A0, /B3, /B2, /B1, /B0, /G, /E, /L
Run mode: Single Run, Sweeps and Corners
