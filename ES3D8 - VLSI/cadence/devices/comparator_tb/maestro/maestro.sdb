ADE simulation setup
Run mode: Single Run, Sweeps and Corners
Tests:
  devices:comparator_tb:1: devices/comparator_tb/schematic, simulator spectre
    Variables: vSupply = 1.1
