ADE simulation setup
Run mode: Single Run, Sweeps and Corners
Tests:
  devices:nor2_pulse_tb:1: devices/nor2_pulse_tb/schematic, simulator spectre
    Variables: vSupply = 1.1
